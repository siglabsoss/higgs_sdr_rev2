/*

This file provides the SystemRDL descriptions for all registers used by the this FPGA.
Used in conjunction with Juniper Network's ORDT tool it provides a central location for registers
definitions and addresses that can be used to generate systemverilog for synthesis and documentation
for software.

Under the current command bus address break down each register file corresponds to a module select index
in the address space.  The registers within the register file are located at dword byte address boundaries
starting at the register file's base address.

The register files are all named rf# where # corresponds to the module select index in the command bus address space.

*/

addrmap {

    regfile {
    
        reg { 
            name="FPGA UID";
            desc="IDs which FPGA in this Copper Suicide array this is by providing the Row and Column as two hex nibbles.";
            
            field {
                name="UID";
                desc="The Row and Column of this FPGA in the Copper Suicide array.";
                hw=w; sw=r;
                reset = 8'b00000000;
            } uid[7:0];
        } fpga_uid; 
        
        reg {
            name="Scratch";
            desc="Scratch register to allow software to test UDP RD/WR commands.";
            
            field {
                hw=na; sw=rw;
                reset = 32'd0;
            } dword[31:0];
        } sw_scratch;
        
        reg {
            name="Analysis Filter Bank Sample Parity Errors";
            desc="Number of parity errors encountered in samples from the Analysis Filter Bank's output since the last reset.";
            
            field {
                hw=na; sw=r; counter;
                reset = 32'd0;
            } cnt[31:0];
        } afb_sample_perrs;

    } rf0 @0x00000;
    
    
    regfile {
    
        reg {
            name="Subcarrier Selector DWORD Mask";
            desc="One of 32 DWORD masks used for selecting which subcarrier samples of the current frame are packetized into UDP packets.";
            
            field {
                hw=r; sw=w;
                reset=32'd0;
            } dword[31:0];
        } sc_mask[32];

    } rf1 @0x10000;
    
    
    regfile {
        
        reg {
            name="Host MAC MSW";
            desc="Upper 16-bits of the Host PC's MAC address";
            
            field {
                hw=r; sw=w;
                reset=16'hffff;
            } bits[15:0];
        } host_mac_msw;
        
        reg {
            name="Host MAC LSW";
            desc="Lower 32-bits of the Host PC's MAC address";
            
            field {
                hw=r; sw=w;
                reset = 32'hffffffff;
            } bits[31:0];
        } host_mac_lsw;

    } rf2 @0x20000;
            
} REGS;
